RC low-pass, fc = 1 kHz
V1 in 0 AC 1
R1 in out 1k
C1 out 0 159.155n
.ac dec 20 10 1meg
.probe v(out)
.end
